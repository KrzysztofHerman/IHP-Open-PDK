//#######################################################################
//
// Copyright 2026 IHP PDK Authors
//
// Licensed under the Apache License, Version 2.0 (the "License");
// you may not use this file except in compliance with the License.
// You may obtain a copy of the License at
//
//    https://www.apache.org/licenses/LICENSE-2.0
//
// Unless required by applicable law or agreed to in writing, software
//distributed under the License is distributed on an "AS IS" BASIS,
// WITHOUT WARRANTIES OR CONDITIONS OF ANY KIND, either express or implied.
// See the License for the specific language governing permissions and
// limitations under the License.
//
//#######################################################################

`ifdef cap_typ
`define cap_carea 1.5E-15
`define cap_cpara 1.0
`include "capacitors_paramsets.vams"
`endif

`ifdef cap_bcs
`define cap_carea 0.9 * 1.5E-15
`define cap_cpara 0.9
`include "capacitors_paramsets.vams"
`endif

`ifdef cap_wcs
`define cap_carea 1.1 * 1.5E-15
`define cap_cpara 1.1
`include "capacitors_paramsets.vams"
`endif

`ifdef cap_stat
`define cap_carea 1.5E-15
`define cap_cpara 1.0
`include "capacitors_paramsets_stat.vams"
`endif
