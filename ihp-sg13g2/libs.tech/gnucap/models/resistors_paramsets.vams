//#######################################################################
//
// Copyright 2026 IHP PDK Authors
//
// Licensed under the Apache License, Version 2.0 (the "License");
// you may not use this file except in compliance with the License.
// You may obtain a copy of the License at
//
//    https://www.apache.org/licenses/LICENSE-2.0
//
// Unless required by applicable law or agreed to in writing, software
//distributed under the License is distributed on an "AS IS" BASIS,
// WITHOUT WARRANTIES OR CONDITIONS OF ANY KIND, either express or implied.
// See the License for the specific language governing permissions and
// limitations under the License.
//
//#######################################################################

`pragma modelgen nogen-module
`pragma modelgen gen-paramset
`include "r3_cmc.va"
`include "resistor.va"

paramset ptap1 sp_resistor

  parameter real R = 262.08;

  .resistance = R;

endparamset

paramset ntap1 sp_resistor

  parameter real R = 262.08;

  .resistance = R;

endparamset

paramset Rparasitic sp_resistor

  parameter real R = `res_rpara;
  parameter real Tc1 = 0.00353;
  parameter real Tc2 = 0.0;

  .resistance = R;

endparamset

paramset rsil r3_cmc

  parameter integer _rdist_seed = 0;
  parameter real w = 0.5e-6 from [0.5e-6:10e-6);
  parameter real l = 0.5e-6 from [0.5e-6:10e-6);
  parameter integer mm_ok = 0  from [0:0];
  parameter real b = 0;
  parameter real m = 1;
  parameter real trise = 0;
  parameter real sw_et = 0;
  parameter real postsim = 0;
  parameter real kappa = 1.85;
  parameter real ps = 0.18e-6;
  parameter real leff = (b + 1) * l + (2 / kappa * w + ps) * b;
  parameter real rzspec = 4.5e-6;
  parameter real lhead = 0.86e-6;
  parameter real cax = 90e-18;
  parameter real cpx = 25e-18;
  parameter real ax = 175e-18 * (1 - 1 / (1.5 * leff * 1e6 + 1)) / cax;
  parameter real px = 115e-18 / cpx;
  parameter real a0 = 0.5 * (leff + lhead) * w - (postsim > 0) * w * ax * 1e-6;
  parameter real a = (a0 > 0) * a0;
  parameter real p0 = leff + lhead + w - (postsim > 0) * px * 1e-6;
  parameter real p = (p0 > 0) * p0;
  parameter real rqrc = 4.5e-6;
  parameter real rz = rzspec / w - (postsim > 0) * rqrc / w;
  parameter real rsh_rsil = `rsh_rsil;

.rsh     = rsh_rsil;
.w       = w;
.l       = leff;
.a1      = a;
.a2      = a;
.p1      = p;
.p2      = p;
.rc      = rz;
.ca      = cax;
.cp      = cpx;
.trise   = trise;
.sw_et   = sw_et;
.c1      = 1;
.c2      = 1;
.xw      = 0.01;
.gth0    = 1e-12;
.gthc    = 1e-12;
.gthp    = 2e-6;
.gtha    = 6e-6;
.cth0    = 0;
.cthc    = 0;
.cthp    = 0;
.ctha    = 594e-15;
.afn     = 1.607;
.bfn     = 1.267;
.kfn     = 2.812e-12;
.sw_mman   = 0;
.smm_w     = 0.01;
.smm_l     = 0.01;
.smm_rsh   = 1.2;
.nsmm_w    = 1;
.nsmm_l    = 1;
.nsmm_rsh  = 1;
.tc1     = 3100e-6;
.tc2     = 0.3e-6;
.tc1rc   = 3100e-6;
.tc2rc   = 0.3e-6;
.dfinf   = 1e-4;
.dp      = 1000;
.ecrit   = 1000;
endparamset

paramset rsil r3_cmc

  parameter integer _rdist_seed = 0;
  parameter real w = 0.5e-6 from [0.1e-6:10e-6);
  parameter real l = 0.5e-6 from [0.5e-6:10e-6);
  parameter integer mm_ok = 0  from [1:1];
  parameter real b = 0;
  parameter real m = 1;
  parameter real trise = 0;
  parameter real sw_et = 0;
  parameter real postsim = 0;
  parameter real kappa = 1.85;
  parameter real ps = 0.18e-6;
  parameter real leff = (b + 1) * l + (2 / kappa * w + ps) * b;
  parameter real rzspec = 4.5e-6;
  parameter real lhead = 0.86e-6;
  parameter real cax = 90e-18;
  parameter real cpx = 25e-18;
  parameter real ax = 175e-18 * (1 - 1 / (1.5 * leff * 1e6 + 1)) / cax;
  parameter real px = 115e-18 / cpx;
  parameter real a0 = 0.5 * (leff + lhead) * w - (postsim > 0) * w * ax * 1e-6;
  parameter real a = (a0 > 0) * a0;
  parameter real p0 = leff + lhead + w - (postsim > 0) * px * 1e-6;
  parameter real p = (p0 > 0) * p0;
  parameter real rqrc = 4.5e-6;
  parameter real rz = rzspec / w - (postsim > 0) * rqrc / w;
  parameter real rsh_rsil = $rdist_normal(_rdist_seed, `rsh_rsil, 0.2);

.rsh     = rsh_rsil;
.w       = w;
.l       = leff;
.a1      = a;
.a2      = a;
.p1      = p;
.p2      = p;
.rc      = rz;
.ca      = cax;
.cp      = cpx;
.trise   = trise;
.sw_et   = sw_et;
.c1      = 1;
.c2      = 1;
.xw      = 0.01;
.gth0    = 1e-12;
.gthc    = 1e-12;
.gthp    = 2e-6;
.gtha    = 6e-6;
.cth0    = 0;
.cthc    = 0;
.cthp    = 0;
.ctha    = 594e-15;
.afn     = 1.607;
.bfn     = 1.267;
.kfn     = 2.812e-12;
.sw_mman   = 1;
.smm_w     = 0.01;
.smm_l     = 0.01;
.smm_rsh   = 1.2;
.nsmm_w    = 1;
.nsmm_l    = 1;
.nsmm_rsh  = 1;
.tc1     = 3100e-6;
.tc2     = 0.3e-6;
.tc1rc   = 3100e-6;
.tc2rc   = 0.3e-6;
.dfinf   = 1e-4;
.dp      = 1000;
.ecrit   = 1000;

endparamset

paramset rhigh r3_cmc

  parameter integer _rdist_seed = 0;
  parameter real w = 0.5e-6 from [0.5e-6:10e-6);
  parameter real l = 0.5e-6 from [0.5e-6:10e-6);
  parameter real b = 0;
  parameter real m = 1;
  parameter real trise = 0;
  parameter real sw_et = 0;
  parameter real postsim = 0;
  parameter real kappa = 1.85;
  parameter real ps = 0.18e-6;
  parameter real leff = (b + 1) * l + (2 / kappa * w + ps) * b;
  parameter real lhead = 0.86e-6;
  parameter real rzspec = 80e-6;
  parameter real cax = 90e-18;
  parameter real cpx = 25e-18;
  parameter real ax = 175e-18 * (1 - 1 / (1.5 * leff * 1e6 + 1)) / cax;
  parameter real px = 115e-18 / cpx;
  parameter real a0 = 0.5 * (leff + lhead) * w - (postsim > 0) * w * ax * 1e-6;
  parameter real a = (a0 > 0) * a0;
  parameter real p0 = leff + lhead + w - (postsim > 0) * px * 1e-6;
  parameter real p = (p0 > 0) * p0;
  parameter real rqrc = 4.5e-6;
  parameter real rz = rzspec / w - (postsim > 0) * rqrc / w;
  parameter real rsh_rhigh = `rsh_rhigh;

.w       = w;
.l       = leff;
.rsh     = rsh_rhigh;
.a1      = a;
.a2      = a;
.p1      = p;
.p2      = p;
.rc      = rz;
.ca      = cax;
.cp      = cpx;
.trise   = trise;
.sw_et   = sw_et;
.c1      = 1;
.c2      = 1;
.xw      = -0.04;
.gth0    = 1e-12;
.gthc    = 1e-12;
.gthp    = 2e-6;
.gtha    = 6e-6;
.cth0    = 0;
.cthc    = 0;
.cthp    = 0;
.ctha    = 594e-15;
.afn     = 1.935;
.bfn     = 0.9086;
.kfn     = 5.205e-10;
.sw_mman   = 0;
.smm_w     = 0.01;
.smm_l     = 0.01;
.smm_rsh   = 5;
.nsmm_w    = 1;
.nsmm_l    = 1;
.nsmm_rsh  = 1;
.tc1     = -2300e-6;
.tc2     = 2.1e-6;
.tc1rc   = -2300e-6;
.tc2rc   = 2.1e-6;
.dfinf   = 1e-4;
.dp      = 1000;
.ecrit   = 1000;

endparamset

paramset rhigh r3_cmc

  parameter integer _rdist_seed = 0;
  parameter real w = 0.5e-6 from [0.1e-6:10e-6);
  parameter real l = 0.5e-6 from [0.5e-6:10e-6);
  parameter integer mm_ok = 0  from (0:1];
  parameter real b = 0;
  parameter real m = 1;
  parameter real trise = 0;
  parameter real sw_et = 0;
  parameter real postsim = 0;
  parameter real kappa = 1.85;
  parameter real ps = 0.18e-6;
  parameter real leff = (b + 1) * l + (2 / kappa * w + ps) * b;
  parameter real lhead = 0.86e-6;
  parameter real rzspec = 80e-6;
  parameter real cax = 90e-18;
  parameter real cpx = 25e-18;
  parameter real ax = 175e-18 * (1 - 1 / (1.5 * leff * 1e6 + 1)) / cax;
  parameter real px = 115e-18 / cpx;
  parameter real a0 = 0.5 * (leff + lhead) * w - (postsim > 0) * w * ax * 1e-6;
  parameter real a = (a0 > 0) * a0;
  parameter real p0 = leff + lhead + w - (postsim > 0) * px * 1e-6;
  parameter real p = (p0 > 0) * p0;
  parameter real rqrc = 4.5e-6;
  parameter real rz = rzspec / w - (postsim > 0) * rqrc / w;
  parameter real rsh_rhigh = $rdist_normal(_rdist_seed, `rsh_rhigh, 120.1);

.w       = w;
.l       = leff;
.rsh     = rsh_rhigh;
.a1      = a;
.a2      = a;
.p1      = p;
.p2      = p;
.rc      = rz;
.ca      = cax;
.cp      = cpx;
.trise   = trise;
.sw_et   = sw_et;
.c1      = 1;
.c2      = 1;
.xw      = -0.04;
.gth0    = 1e-12;
.gthc    = 1e-12;
.gthp    = 2e-6;
.gtha    = 6e-6;
.cth0    = 0;
.cthc    = 0;
.cthp    = 0;
.ctha    = 594e-15;
.afn     = 1.935;
.bfn     = 0.9086;
.kfn     = 5.205e-10;
.sw_mman   = 1;
.smm_w     = 0.01;
.smm_l     = 0.01;
.smm_rsh   = 5;
.nsmm_w    = 1;
.nsmm_l    = 1;
.nsmm_rsh  = 1;
.tc1     = -2300e-6;
.tc2     = 2.1e-6;
.tc1rc   = -2300e-6;
.tc2rc   = 2.1e-6;
.dfinf   = 1e-4;
.dp      = 1000;
.ecrit   = 1000;

endparamset

paramset rppd r3_cmc

  parameter integer _rdist_seed = 0;
  parameter real w = 0.5e-6 from [0.5e-6:10e-6);
  parameter real l = 0.5e-6 from [0.5e-6:10e-6);
  parameter integer mm_ok = 0  from [0:0];
  parameter real b = 0;
  parameter real m = 1;
  parameter real trise = 0;
  parameter real sw_et = 0;
  parameter real postsim = 0;
  parameter real kappa = 1.85;
  parameter real ps = 0.18e-6;
  parameter real leff = (b + 1) * l + (2 / kappa * w + ps) * b;
  parameter real lhead = 0.86e-6;
  parameter real rzspec = 35e-6;
  parameter real cax = 90e-18;
  parameter real cpx = 25e-18;
  parameter real ax = 175e-18 * (1 - 1 / (1.5 * leff * 1e6 + 1)) / cax;
  parameter real px = 115e-18 / cpx;
  parameter real a0 = 0.5 * (leff + lhead) * w - (postsim > 0) * w * ax * 1e-6;
  parameter real a = (a0 > 0) * a0;
  parameter real p0 = leff + lhead + w - (postsim > 0) * px * 1e-6;
  parameter real p = (p0 > 0) * p0;
  parameter real rqrc = 4.5e-6;
  parameter real rz = rzspec / w - (postsim > 0) * rqrc / w;
  parameter real rsh_rppd = `rsh_rppd;

.w       = w;
.l       = leff;
.rsh     = rsh_rppd;
.a1      = a;
.a2      = a;
.p1      = p;
.p2      = p;
.rc      = rz;
.ca      = cax;
.cp      = cpx;
.trise   = trise;
.sw_et   = sw_et;
.sw_mman   = 0;
.c1      = 1;
.c2      = 1;
.xw      = 0.006;
.gth0    = 1e-12;
.gthc    = 1e-12;
.gthp    = 2e-6;
.gtha    = 6e-6;
.cth0    = 0;
.cthc    = 0;
.cthp    = 0;
.ctha    = 594e-15;
.afn     = 1.886;
.bfn     = 0.9963;
.kfn     = 4.601e-11;
.smm_w     = 0.01;
.smm_l     = 0.01;
.smm_rsh   = 1.5;
.nsmm_w    = 1;
.nsmm_l    = 1;
.nsmm_rsh  = 1;
.tc1     = 170e-6;
.tc2     = 0.4e-6;
.tc1rc   = -950e-6;
.dfinf   = 1e-4;
.dp      = 1000;
.ecrit   = 1000;

endparamset

paramset rppd r3_cmc

  parameter integer _rdist_seed = 0;
  parameter real w = 0.5e-6 from [0.1e-6:10e-6);
  parameter real l = 0.5e-6 from [0.5e-6:10e-6);
  parameter integer mm_ok = 0  from [1:1];
  parameter real b = 0;
  parameter real m = 1;
  parameter real trise = 0;
  parameter real sw_et = 0;
  parameter real postsim = 0;
  parameter real kappa = 1.85;
  parameter real ps = 0.18e-6;
  parameter real leff = (b + 1) * l + (2 / kappa * w + ps) * b;
  parameter real lhead = 0.86e-6;
  parameter real rzspec = 35e-6;
  parameter real cax = 90e-18;
  parameter real cpx = 25e-18;
  parameter real ax = 175e-18 * (1 - 1 / (1.5 * leff * 1e6 + 1)) / cax;
  parameter real px = 115e-18 / cpx;
  parameter real a0 = 0.5 * (leff + lhead) * w - (postsim > 0) * w * ax * 1e-6;
  parameter real a = (a0 > 0) * a0;
  parameter real p0 = leff + lhead + w - (postsim > 0) * px * 1e-6;
  parameter real p = (p0 > 0) * p0;
  parameter real rqrc = 4.5e-6;
  parameter real rz = rzspec / w - (postsim > 0) * rqrc / w;
  parameter real rsh_rppd = $rdist_normal(_rdist_seed, `rsh_rppd, 0.015);

.w       = w;
.l       = leff;
.rsh     = rsh_rppd;
.a1      = a;
.a2      = a;
.p1      = p;
.p2      = p;
.rc      = rz;
.ca      = cax;
.cp      = cpx;
.trise   = trise;
.sw_et   = sw_et;
.sw_mman   = mm_ok;
.c1      = 1;
.c2      = 1;
.xw      = 0.006;
.gth0    = 1e-12;
.gthc    = 1e-12;
.gthp    = 2e-6;
.gtha    = 6e-6;
.cth0    = 0;
.cthc    = 0;
.cthp    = 0;
.ctha    = 594e-15;
.afn     = 1.886;
.bfn     = 0.9963;
.kfn     = 4.601e-11;
.smm_w     = 0.01;
.smm_l     = 0.01;
.smm_rsh   = 1.5;
.nsmm_w    = 1;
.nsmm_l    = 1;
.nsmm_rsh  = 1;
.tc1     = 170e-6;
.tc2     = 0.4e-6;
.tc1rc   = -950e-6;
.dfinf   = 1e-4;
.dp      = 1000;
.ecrit   = 1000;

endparamset
