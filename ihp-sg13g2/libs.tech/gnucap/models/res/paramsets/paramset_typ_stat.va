paramset rsil_typ resistors;
  parameter real w = 0.3u from (0.5u:10.0u);
  parameter real l = 0.5u  from (0.5:inf);
  .w = w; .l = l;

  .rsil_rsh = res_typ_stat.rsh_rsil_eff;
endparamset
