`include "disciplines.vams"

paramset rsil R3_CMC;

  parameter integer _rdist_seed = 0;
  parameter real w = 0.5e-6 from (0.1e-6:10e-6);
  parameter real l = 0.5e-6 from (0.5e-6:10e-6);
  parameter real mm_ok = 1;
  parameter real b = 0;
  parameter real m = 1;
  parameter real trise = 0;
  parameter real sw_et = 0;
  parameter real postsim = 0;
  parameter real kappa = 1.85;
  parameter real ps = 0.18e-6;
  parameter real weff = w + 0.01e-6;
  parameter real leff = (b + 1) * l + (2 / kappa * weff + ps) * b;
  parameter real rzspec = 4.5e-6;
  parameter real lhead = 0.86e-6;
  parameter real cax = 90e-18;
  parameter real cpx = 25e-18;
  parameter real ax = 175e-18 * (1 - 1 / (1.5 * leff * 1e6 + 1)) / cax;
  parameter real px = 115e-18 / cpx;
  parameter real a0 = 0.5 * (leff + lhead) * w - (postsim > 0) * w * ax * 1e-6;
  parameter real a = (a0 > 0) * a0;
  parameter real p0 = leff + lhead + w - (postsim > 0) * px * 1e-6;
  parameter real p = (p0 > 0) * p0;
  parameter real rshspec = 7;
  parameter real rqrc = 4.5e-6;
  parameter real rz = rzspec / w - (postsim > 0) * rqrc / w;

  .rsil_rsh = res_typ.rsh_rsil_eff;
endparamset

// Does not contain mm_ok parameter
paramset rsil R3_CMC;

  parameter integer _rdist_seed = 0;
  parameter real w = 0.5e-6 from (0.1e-6:10e-6);
  parameter real l = 0.5e-6 from (0.5e-6:10e-6);
  parameter real b = 0;
  parameter real m = 1;
  parameter real trise = 0;
  parameter real sw_et = 0;
  parameter real postsim = 0;
  parameter real kappa = 1.85;
  parameter real ps = 0.18e-6;
  parameter real weff = w + 0.01e-6;
  parameter real leff = (b + 1) * l + (2 / kappa * weff + ps) * b;
  parameter real rzspec = 4.5e-6;
  parameter real lhead = 0.86e-6;
  parameter real cax = 90e-18;
  parameter real cpx = 25e-18;
  parameter real ax = 175e-18 * (1 - 1 / (1.5 * leff * 1e6 + 1)) / cax;
  parameter real px = 115e-18 / cpx;
  parameter real a0 = 0.5 * (leff + lhead) * w - (postsim > 0) * w * ax * 1e-6;
  parameter real a = (a0 > 0) * a0;
  parameter real p0 = leff + lhead + w - (postsim > 0) * px * 1e-6;
  parameter real p = (p0 > 0) * p0;
  parameter real rshspec = 7;
  parameter real rqrc = 4.5e-6;
  parameter real rz = rzspec / w - (postsim > 0) * rqrc / w;

  .rsil_rsh = res_typ.rsh_rsil_eff;
endparamset
