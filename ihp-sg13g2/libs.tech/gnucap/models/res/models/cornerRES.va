`include "disciplines.vams"

`ifdef res_typ
`include "resistors_mod.va"
`include "paramset_typ.va"
`endif

`ifdef res_typ_stat
`include "resistors_mod.va"
`include "paramset_typ_stat.va"
`endif

`
