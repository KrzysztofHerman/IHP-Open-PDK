//#######################################################################
//
// Copyright 2026 IHP PDK Authors
//
// Licensed under the Apache License, Version 2.0 (the "License");
// you may not use this file except in compliance with the License.
// You may obtain a copy of the License at
//
//    https://www.apache.org/licenses/LICENSE-2.0
//
// Unless required by applicable law or agreed to in writing, software
//distributed under the License is distributed on an "AS IS" BASIS,
// WITHOUT WARRANTIES OR CONDITIONS OF ANY KIND, either express or implied.
// See the License for the specific language governing permissions and
// limitations under the License.
//
//#######################################################################

// This
module res_typ_stat();
  // ---- seeds (constants) ----
  parameter integer SEED = 101;

  // ---- nominal (per corner) ----
  parameter real rsh_rsil_nom = 7.0;     // ohm/sq (example)
  parameter real rsh_rhigh_nom = 1360;   // ohm/sq (example)
  parameter real rsh_rppd_nom = 260.0;   // ohm/sq (example)
  parameter real res_rpara_nom = 1.0;   // ohm/sq (example)
  parameter real res_rarea_nom = 1.0;   // ohm/sq (example)

  // ---- 1-sigma variations (example numbers) ----
  parameter real rsh_rsil_sigma_g = 0.0467; // ohm/sq global
  parameter real rsh_rhigh_sigma_g = 0.0833; // ohm/sq global
  parameter real rsh_rppd_sigma_g = 0.033; // ohm/sq global
  parameter real res_rpara_sigma_g = 0.067; // ohm/sq local
  parameter real res_rarea_sigma_g = 0.033; // ohm/sq local
  parameter real rsh_rsil_sigma_l = 0.2; // ohm/sq local
  parameter real rsh_rhigh_sigma_l = 0.05; // ohm/sq local
  parameter real rsh_rppd_sigma_l = 0.12; // ohm/sq local

  // ---- global (shared across instances) ----
  // parameter real drsh_g = $rdist_normal(SEED, 0.0, rsh_rsil_sigma_g, "global");
  parameter real drsh_g = $rdist_normal(SEED, 0.0, rsh_rsil_sigma_g);
  parameter real drsh_rhigh_g = $rdist_normal(SEED, 0.0, rsh_rhigh_sigma_g);
  parameter real drsh_rppd_g = $rdist_normal(SEED, 0.0, rsh_rppd_sigma_g);

  // ---- local (instance mismatch) ----
  // parameter real drsh_l = $rdist_normal(SEED, 0.0, rsh_rsil_sigma_l, "instance");
  parameter real drsh_l = $rdist_normal(SEED, 0.0, rsh_rsil_sigma_l);
  parameter real drsh_rhigh_l = $rdist_normal(SEED, 0.0, rsh_rhigh_sigma_l);
  parameter real drsh_rppd_l = $rdist_normal(SEED, 0.0, rsh_rppd_sigma_l);

  // ---- final effective params for this corner ----
  parameter real rsh_rsil_eff = rsh_rsil_nom + drsh_g + drsh_l;
  parameter real rsh_rhigh_eff = rsh_rhigh_nom + drsh_rhigh_g + drsh_rhigh_l;
  parameter real rsh_rppd_eff = rsh_rppd_nom + drsh_rppd_g + drsh_rppd_l;
endmodule

module res_typ();
  // ---- seeds (constants) ----
  parameter real SEED = 101;

  parameter real sig_rsil = 0.0;
  parameter real sig_rppd = 0.0;
  parameter real sig_rhigh = 0.0;

  // ---- nominal (per corner) ----
  parameter real rsh_rsil_nom = 7.0;     // ohm/sq (example)
  parameter real rsh_rhigh_nom = 1360;   // ohm/sq (example)
  parameter real rsh_rppd_nom = 260.0;   // ohm/sq (example)
  parameter real res_rpara_nom = 1.0;    // ohm/sq (example)

  // ---- 1-sigma variations (example numbers) ----
  parameter real rsh_rsil_sigma_g = 0.0467; // ohm/sq global
  parameter real rsh_rhigh_sigma_g = 0.0833; // ohm/sq global
  parameter real rsh_rppd_sigma_g = 0.033; // ohm/sq global
  parameter real res_rpara_sigma_g = 0.067; // ohm/sq local
  parameter real res_rarea_sigma_g = 0.033; // ohm/sq local
  parameter real rsh_rsil_sigma_l = 0.2; // ohm/sq local
  parameter real rsh_rhigh_sigma_l = 0.05; // ohm/sq local
  parameter real rsh_rppd_sigma_l = 0.12; // ohm/sq local

  // ---- local (instance mismatch) ----
  parameter real drsh_rsil_l = sig_rsil;
  parameter real drsh_rhigh_l = sig_rhigh;
  parameter real drsh_rppd_l = sig_rppd;

  // ---- final effective params for this corner ----
  parameter real rsh_rsil_eff = rsh_rsil_nom  + drsh_rsil_l;
  parameter real rsh_rhigh_eff = rsh_rhigh_nom + drsh_rhigh_l;
  parameter real rsh_rppd_eff = rsh_rppd_nom + drsh_rppd_l;
endmodule
