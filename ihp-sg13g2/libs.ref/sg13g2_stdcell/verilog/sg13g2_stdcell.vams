// Copyright 2024 IHP PDK Authors
//
// Licensed under the Apache License, Version 2.0 (the "License");
// you may not use this file except in compliance with the License.
// You may obtain a copy of the License at
//
//    https://www.apache.org/licenses/LICENSE-2.0
//
// Unless required by applicable law or agreed to in writing, software
// distributed under the License is distributed on an "AS IS" BASIS,
// WITHOUT WARRANTIES OR CONDITIONS OF ANY KIND, either express or implied.
// See the License for the specific language governing permissions and
// limitations under the License.

`include "disciplines.vams"

module sg13g2_nand2_1(Y, A, B);

input A, B;
output Y;
electrical Y;
electrical A, B;
parameter real vh = 1.2;			// output electrical in high state
parameter real vl = 0;			    // output electrical in low state
parameter real vth = (vh + vl)/2;	// threshold electrical at inputs
parameter real td = 0 from [0:inf);	// delay to start of output transition
parameter real tt = 0 from [0:inf);	// transition time of output signals

analog begin
    @(cross(V(A) - vth) or cross(V(B) - vth));

    V(Y) <+ transition( !((V(A) > vth) && (V(B) > vth)) ? vh : vl, td, tt );
end
endmodule

module sg13g2_dfrbpq_1 (Q, D, RESET_B, CLK);

output Q;
electrical Q;	// Q output
input D;
electrical D;	// D input
input RESET_B;
electrical RESET_B;	// Clock input (edge triggered)
input CLK;
electrical CLK;	// D input
parameter real td = 0 from [0:inf);	// delay from clock to q
parameter real tt = 0 from [0:inf);	// transition time of output signals
parameter real vh = 1.2;			// output voltage in high state
parameter real vl = 0;			// output voltage in low state
parameter real vth = (vh + vl)/2;	// threshold voltage at inputs
parameter integer dir = +1 from [-1:+1] exclude 0;
			// if dir=+1, rising clock edge triggers flip flop
			// if dir=-1, falling clock edge triggers flip flop
real state;

analog begin
    @(cross(V(CLK) - vth, dir))
	state = (V(D) > vth);
    if (V(RESET_B) < vth)
        state = 0;
    V(Q) <+ transition( state ? vh : vl, td, tt );
end
endmodule
