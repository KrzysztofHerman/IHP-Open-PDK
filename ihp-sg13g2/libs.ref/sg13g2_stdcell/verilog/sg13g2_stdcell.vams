// Copyright 2024 IHP PDK Authors
//
// Licensed under the Apache License, Version 2.0 (the "License");
// you may not use this file except in compliance with the License.
// You may obtain a copy of the License at
//
//    https://www.apache.org/licenses/LICENSE-2.0
//
// Unless required by applicable law or agreed to in writing, software
// distributed under the License is distributed on an "AS IS" BASIS,
// WITHOUT WARRANTIES OR CONDITIONS OF ANY KIND, either express or implied.
// See the License for the specific language governing permissions and
// limitations under the License.

`include "disciplines.vams"

// Analog behavior parameters are declared per cell to mirror digital functionality

// Basic combinational helpers
module sg13g2_buf_base (X, A);
    output X;
    electrical X;
    input A;
    electrical A;
    parameter real vh = 1.2; /* high level */
    parameter real vl = 0;   /* low level */
    parameter real vth = (vh + vl)/2;
    parameter real td = 0 from [0:inf);
    parameter real tt = 0 from [0:inf);
analog begin
    @(cross(V(A) - vth));

    V(X) <+ transition((V(A) > vth) ? vh : vl, td, tt);
end
endmodule

module sg13g2_inv_base (Y, A);
    output Y;
    electrical Y;
    input A;
    electrical A;
    parameter real vh = 1.2; /* high level */
    parameter real vl = 0;   /* low level */
    parameter real vth = (vh + vl)/2;
    parameter real td = 0 from [0:inf);
    parameter real tt = 0 from [0:inf);
analog begin
    @(cross(V(A) - vth));

    V(Y) <+ transition(!(V(A) > vth) ? vh : vl, td, tt);
end
endmodule

// Combinational cells
module sg13g2_a21o_1 (X, A1, A2, B1);
    output X;
    electrical X;
    input A1, A2, B1;
    electrical A1, A2, B1;
    parameter real vh = 1.2; /* high level */
    parameter real vl = 0;   /* low level */
    parameter real vth = (vh + vl)/2;
    parameter real td = 0 from [0:inf);
    parameter real tt = 0 from [0:inf);
analog begin
    @(cross(V(A1)-vth) or cross(V(A2)-vth) or cross(V(B1)-vth));

    V(X) <+ transition(((V(A1) > vth) && (V(A2) > vth)) || (V(B1) > vth) ? vh : vl, td, tt);
end
endmodule

module sg13g2_a21o_2 (X, A1, A2, B1);
    output X;
    electrical X;
    input A1, A2, B1;
    electrical A1, A2, B1;
    parameter real vh = 1.2; /* high level */
    parameter real vl = 0;   /* low level */
    parameter real vth = (vh + vl)/2;
    parameter real td = 0 from [0:inf);
    parameter real tt = 0 from [0:inf);
analog begin
    @(cross(V(A1)-vth) or cross(V(A2)-vth) or cross(V(B1)-vth));

    V(X) <+ transition(((V(A1) > vth) && (V(A2) > vth)) || (V(B1) > vth) ? vh : vl, td, tt);
end
endmodule

module sg13g2_a21oi_1 (Y, A1, A2, B1);
    output Y;
    electrical Y;
    input A1, A2, B1;
    electrical A1, A2, B1;
    parameter real vh = 1.2; /* high level */
    parameter real vl = 0;   /* low level */
    parameter real vth = (vh + vl)/2;
    parameter real td = 0 from [0:inf);
    parameter real tt = 0 from [0:inf);
analog begin
    @(cross(V(A1)-vth) or cross(V(A2)-vth) or cross(V(B1)-vth));

    V(Y) <+ transition(!(((V(A1) > vth) && (V(A2) > vth)) || (V(B1) > vth)) ? vh : vl, td, tt);
end
endmodule

module sg13g2_a21oi_2 (Y, A1, A2, B1);
    output Y;
    electrical Y;
    input A1, A2, B1;
    electrical A1, A2, B1;
    parameter real vh = 1.2; /* high level */
    parameter real vl = 0;   /* low level */
    parameter real vth = (vh + vl)/2;
    parameter real td = 0 from [0:inf);
    parameter real tt = 0 from [0:inf);
analog begin
    @(cross(V(A1)-vth) or cross(V(A2)-vth) or cross(V(B1)-vth));

    V(Y) <+ transition(!(((V(A1) > vth) && (V(A2) > vth)) || (V(B1) > vth)) ? vh : vl, td, tt);
end
endmodule

module sg13g2_a221oi_1 (Y, A1, A2, B1, B2, C1);
    output Y;
    electrical Y;
    input A1, A2, B1, B2, C1;
    electrical A1, A2, B1, B2, C1;
    parameter real vh = 1.2; /* high level */
    parameter real vl = 0;   /* low level */
    parameter real vth = (vh + vl)/2;
    parameter real td = 0 from [0:inf);
    parameter real tt = 0 from [0:inf);
analog begin
    @(cross(V(A1)-vth) or cross(V(A2)-vth) or cross(V(B1)-vth) or cross(V(B2)-vth) or cross(V(C1)-vth));

    V(Y) <+ transition(!(((V(A1) > vth)&&(V(A2) > vth)) || ((V(B1) > vth)&&(V(B2) > vth)) || (V(C1) > vth)) ? vh : vl, td, tt);
end
endmodule

module sg13g2_a22oi_1 (Y, A1, A2, B1, B2);
    output Y;
    electrical Y;
    input A1, A2, B1, B2;
    electrical A1, A2, B1, B2;
    parameter real vh = 1.2; /* high level */
    parameter real vl = 0;   /* low level */
    parameter real vth = (vh + vl)/2;
    parameter real td = 0 from [0:inf);
    parameter real tt = 0 from [0:inf);
analog begin
    @(cross(V(A1)-vth) or cross(V(A2)-vth) or cross(V(B1)-vth) or cross(V(B2)-vth));

    V(Y) <+ transition(!(((V(A1) > vth)&&(V(A2) > vth)) || ((V(B1) > vth)&&(V(B2) > vth))) ? vh : vl, td, tt);
end
endmodule

module sg13g2_and2_1 (X, A, B);
    output X;
    electrical X;
    input A, B;
    electrical A, B;
    parameter real vh = 1.2; /* high level */
    parameter real vl = 0;   /* low level */
    parameter real vth = (vh + vl)/2;
    parameter real td = 0 from [0:inf);
    parameter real tt = 0 from [0:inf);
analog begin
    @(cross(V(A)-vth) or cross(V(B)-vth));

    V(X) <+ transition((V(A) > vth) && (V(B) > vth) ? vh : vl, td, tt);
end
endmodule

module sg13g2_and2_2 (X, A, B);
    output X;
    electrical X;
    input A, B;
    electrical A, B;
    parameter real vh = 1.2; /* high level */
    parameter real vl = 0;   /* low level */
    parameter real vth = (vh + vl)/2;
    parameter real td = 0 from [0:inf);
    parameter real tt = 0 from [0:inf);
analog begin
    @(cross(V(A)-vth) or cross(V(B)-vth));

    V(X) <+ transition((V(A) > vth) && (V(B) > vth) ? vh : vl, td, tt);
end
endmodule

module sg13g2_and3_1 (X, A, B, C);
    output X;
    electrical X;
    input A, B, C;
    electrical A, B, C;
    parameter real vh = 1.2; /* high level */
    parameter real vl = 0;   /* low level */
    parameter real vth = (vh + vl)/2;
    parameter real td = 0 from [0:inf);
    parameter real tt = 0 from [0:inf);
analog begin
    @(cross(V(A)-vth) or cross(V(B)-vth) or cross(V(C)-vth));

    V(X) <+ transition((V(A) > vth) && (V(B) > vth) && (V(C) > vth) ? vh : vl, td, tt);
end
endmodule

module sg13g2_and3_2 (X, A, B, C);
    output X;
    electrical X;
    input A, B, C;
    electrical A, B, C;
    parameter real vh = 1.2; /* high level */
    parameter real vl = 0;   /* low level */
    parameter real vth = (vh + vl)/2;
    parameter real td = 0 from [0:inf);
    parameter real tt = 0 from [0:inf);
analog begin
    @(cross(V(A)-vth) or cross(V(B)-vth) or cross(V(C)-vth));

    V(X) <+ transition((V(A) > vth) && (V(B) > vth) && (V(C) > vth) ? vh : vl, td, tt);
end
endmodule

module sg13g2_and4_1 (X, A, B, C, D);
    output X;
    electrical X;
    input A, B, C, D;
    electrical A, B, C, D;
    parameter real vh = 1.2; /* high level */
    parameter real vl = 0;   /* low level */
    parameter real vth = (vh + vl)/2;
    parameter real td = 0 from [0:inf);
    parameter real tt = 0 from [0:inf);
analog begin
    @(cross(V(A)-vth) or cross(V(B)-vth) or cross(V(C)-vth) or cross(V(D)-vth));

    V(X) <+ transition((V(A) > vth) && (V(B) > vth) && (V(C) > vth) && (V(D) > vth) ? vh : vl, td, tt);
end
endmodule

module sg13g2_and4_2 (X, A, B, C, D);
    output X;
    electrical X;
    input A, B, C, D;
    electrical A, B, C, D;
    parameter real vh = 1.2; /* high level */
    parameter real vl = 0;   /* low level */
    parameter real vth = (vh + vl)/2;
    parameter real td = 0 from [0:inf);
    parameter real tt = 0 from [0:inf);
analog begin
    @(cross(V(A)-vth) or cross(V(B)-vth) or cross(V(C)-vth) or cross(V(D)-vth));

    V(X) <+ transition((V(A) > vth) && (V(B) > vth) && (V(C) > vth) && (V(D) > vth) ? vh : vl, td, tt);
end
endmodule

// Antenna/filler/decap cells do not drive signals
module sg13g2_antennanp (A);
    input A;
    electrical A;
endmodule
module sg13g2_fill_1(); endmodule
module sg13g2_fill_2(); endmodule
module sg13g2_fill_4(); endmodule
module sg13g2_fill_8(); endmodule
module sg13g2_decap_4(); endmodule
module sg13g2_decap_8(); endmodule

// Buffers and inverters
module sg13g2_buf_1 (X, A);
    output X;
    electrical X;
    input A;
    electrical A;
    sg13g2_buf_base buf_i(.X(X), .A(A));
endmodule
module sg13g2_buf_2 (X, A);
    output X;
    electrical X;
    input A;
    electrical A;
    sg13g2_buf_base buf_i(.X(X), .A(A));
endmodule
module sg13g2_buf_4 (X, A);
    output X;
    electrical X;
    input A;
    electrical A;
    sg13g2_buf_base buf_i(.X(X), .A(A));
endmodule
module sg13g2_buf_8 (X, A);
    output X;
    electrical X;
    input A;
    electrical A;
    sg13g2_buf_base buf_i(.X(X), .A(A));
endmodule
module sg13g2_buf_16 (X, A);
    output X;
    electrical X;
    input A;
    electrical A;
    sg13g2_buf_base buf_i(.X(X), .A(A));
endmodule

module sg13g2_inv_1 (Y, A);
    output Y;
    electrical Y;
    input A;
    electrical A;
    sg13g2_inv_base inv_i(.Y(Y), .A(A));
endmodule
module sg13g2_inv_2 (Y, A);
    output Y;
    electrical Y;
    input A;
    electrical A;
    sg13g2_inv_base inv_i(.Y(Y), .A(A));
endmodule
module sg13g2_inv_4 (Y, A);
    output Y;
    electrical Y;
    input A;
    electrical A;
    sg13g2_inv_base inv_i(.Y(Y), .A(A));
endmodule
module sg13g2_inv_8 (Y, A);
    output Y;
    electrical Y;
    input A;
    electrical A;
    sg13g2_inv_base inv_i(.Y(Y), .A(A));
endmodule
module sg13g2_inv_16 (Y, A);
    output Y;
    electrical Y;
    input A;
    electrical A;
    sg13g2_inv_base inv_i(.Y(Y), .A(A));
endmodule

// Multiplexers
module sg13g2_mux2_1 (X, A0, A1, S);
    output X;
    electrical X;
    input A0, A1, S;
    electrical A0, A1, S;
    parameter real vh = 1.2; /* high level */
    parameter real vl = 0;   /* low level */
    parameter real vth = (vh + vl)/2;
    parameter real td = 0 from [0:inf);
    parameter real tt = 0 from [0:inf);
analog begin
    @(cross(V(A0)-vth) or cross(V(A1)-vth) or cross(V(S)-vth));

    V(X) <+ transition((V(S) > vth) ? ((V(A1) > vth)?vh:vl) : ((V(A0) > vth)?vh:vl), td, tt);
end
endmodule

module sg13g2_mux2_2 (X, A0, A1, S);
    output X;
    electrical X;
    input A0, A1, S;
    electrical A0, A1, S;
    parameter real vh = 1.2; /* high level */
    parameter real vl = 0;   /* low level */
    parameter real vth = (vh + vl)/2;
    parameter real td = 0 from [0:inf);
    parameter real tt = 0 from [0:inf);
analog begin
    @(cross(V(A0)-vth) or cross(V(A1)-vth) or cross(V(S)-vth));

    V(X) <+ transition((V(S) > vth) ? ((V(A1) > vth)?vh:vl) : ((V(A0) > vth)?vh:vl), td, tt);
end
endmodule

module sg13g2_mux4_1 (X, A0, A1, A2, A3, S0, S1);
    output X;
    electrical X;
    input A0, A1, A2, A3, S0, S1;
    electrical A0, A1, A2, A3, S0, S1;
    parameter real vh = 1.2; /* high level */
    parameter real vl = 0;   /* low level */
    parameter real vth = (vh + vl)/2;
    parameter real td = 0 from [0:inf);
    parameter real tt = 0 from [0:inf);
analog begin
    @(cross(V(A0)-vth) or cross(V(A1)-vth) or cross(V(A2)-vth) or cross(V(A3)-vth) or cross(V(S0)-vth) or cross(V(S1)-vth)) begin;

        integer sel0, sel1;
        sel0 = (V(S0) > vth);
        sel1 = (V(S1) > vth);
        if (!sel1 && !sel0)
            V(X) <+ transition((V(A0) > vth)?vh:vl, td, tt);
        else if (!sel1 && sel0)
            V(X) <+ transition((V(A1) > vth)?vh:vl, td, tt);
        else if (sel1 && !sel0)
            V(X) <+ transition((V(A2) > vth)?vh:vl, td, tt);
        else
            V(X) <+ transition((V(A3) > vth)?vh:vl, td, tt);
    end
end
endmodule

// NAND / NOR variations
module sg13g2_nand2_1 (Y, A, B);
    output Y;
    electrical Y;
    input A, B;
    electrical A, B;
    parameter real vh = 1.2; /* high level */
    parameter real vl = 0;   /* low level */
    parameter real vth = (vh + vl)/2;
    parameter real td = 0 from [0:inf);
    parameter real tt = 0 from [0:inf);
analog begin
    @(cross(V(A)-vth) or cross(V(B)-vth));

    V(Y) <+ transition(!((V(A) > vth) && (V(B) > vth)) ? vh : vl, td, tt);
end
endmodule

module sg13g2_nand2_2 (Y, A, B);
    output Y;
    electrical Y;
    input A, B;
    electrical A, B;
    parameter real vh = 1.2; /* high level */
    parameter real vl = 0;   /* low level */
    parameter real vth = (vh + vl)/2;
    parameter real td = 0 from [0:inf);
    parameter real tt = 0 from [0:inf);
analog begin
    @(cross(V(A)-vth) or cross(V(B)-vth));

    V(Y) <+ transition(!((V(A) > vth) && (V(B) > vth)) ? vh : vl, td, tt);
end
endmodule

module sg13g2_nand2b_1 (Y, A_N, B);
    output Y;
    electrical Y;
    input A_N, B;
    electrical A_N, B;
    parameter real vh = 1.2; /* high level */
    parameter real vl = 0;   /* low level */
    parameter real vth = (vh + vl)/2;
    parameter real td = 0 from [0:inf);
    parameter real tt = 0 from [0:inf);
analog begin
    @(cross(V(A_N)-vth) or cross(V(B)-vth));

    V(Y) <+ transition(!((!(V(A_N) > vth)) && (V(B) > vth)) ? vh : vl, td, tt);
end
endmodule

module sg13g2_nand2b_2 (Y, A_N, B);
    output Y;
    electrical Y;
    input A_N, B;
    electrical A_N, B;
    parameter real vh = 1.2; /* high level */
    parameter real vl = 0;   /* low level */
    parameter real vth = (vh + vl)/2;
    parameter real td = 0 from [0:inf);
    parameter real tt = 0 from [0:inf);
analog begin
    @(cross(V(A_N)-vth) or cross(V(B)-vth));

    V(Y) <+ transition(!((!(V(A_N) > vth)) && (V(B) > vth)) ? vh : vl, td, tt);
end
endmodule

module sg13g2_nand3_1 (Y, A, B, C);
    output Y;
    electrical Y;
    input A, B, C;
    electrical A, B, C;
    parameter real vh = 1.2; /* high level */
    parameter real vl = 0;   /* low level */
    parameter real vth = (vh + vl)/2;
    parameter real td = 0 from [0:inf);
    parameter real tt = 0 from [0:inf);
analog begin
    @(cross(V(A)-vth) or cross(V(B)-vth) or cross(V(C)-vth));

    V(Y) <+ transition(!((V(A) > vth)&&(V(B) > vth)&&(V(C) > vth)) ? vh : vl, td, tt);
end
endmodule

module sg13g2_nand3b_1 (Y, A_N, B, C);
    output Y;
    electrical Y;
    input A_N, B, C;
    electrical A_N, B, C;
    parameter real vh = 1.2; /* high level */
    parameter real vl = 0;   /* low level */
    parameter real vth = (vh + vl)/2;
    parameter real td = 0 from [0:inf);
    parameter real tt = 0 from [0:inf);
analog begin
    @(cross(V(A_N)-vth) or cross(V(B)-vth) or cross(V(C)-vth));

    V(Y) <+ transition(!((!(V(A_N) > vth))&&(V(B) > vth)&&(V(C) > vth)) ? vh : vl, td, tt);
end
endmodule

module sg13g2_nand4_1 (Y, A, B, C, D);
    output Y;
    electrical Y;
    input A, B, C, D;
    electrical A, B, C, D;
    parameter real vh = 1.2; /* high level */
    parameter real vl = 0;   /* low level */
    parameter real vth = (vh + vl)/2;
    parameter real td = 0 from [0:inf);
    parameter real tt = 0 from [0:inf);
analog begin
    @(cross(V(A)-vth) or cross(V(B)-vth) or cross(V(C)-vth) or cross(V(D)-vth));

    V(Y) <+ transition(!((V(A) > vth)&&(V(B) > vth)&&(V(C) > vth)&&(V(D) > vth)) ? vh : vl, td, tt);
end
endmodule

module sg13g2_nor2_1 (Y, A, B);
    output Y;
    electrical Y;
    input A, B;
    electrical A, B;
    parameter real vh = 1.2; /* high level */
    parameter real vl = 0;   /* low level */
    parameter real vth = (vh + vl)/2;
    parameter real td = 0 from [0:inf);
    parameter real tt = 0 from [0:inf);
analog begin
    @(cross(V(A)-vth) or cross(V(B)-vth));

    V(Y) <+ transition(!((V(A) > vth) || (V(B) > vth)) ? vh : vl, td, tt);
end
endmodule

module sg13g2_nor2_2 (Y, A, B);
    output Y;
    electrical Y;
    input A, B;
    electrical A, B;
    parameter real vh = 1.2; /* high level */
    parameter real vl = 0;   /* low level */
    parameter real vth = (vh + vl)/2;
    parameter real td = 0 from [0:inf);
    parameter real tt = 0 from [0:inf);
analog begin
    @(cross(V(A)-vth) or cross(V(B)-vth));

    V(Y) <+ transition(!((V(A) > vth) || (V(B) > vth)) ? vh : vl, td, tt);
end
endmodule

module sg13g2_nor2b_1 (Y, A, B_N);
    output Y;
    electrical Y;
    input A, B_N;
    electrical A, B_N;
    parameter real vh = 1.2; /* high level */
    parameter real vl = 0;   /* low level */
    parameter real vth = (vh + vl)/2;
    parameter real td = 0 from [0:inf);
    parameter real tt = 0 from [0:inf);
analog begin
    @(cross(V(A)-vth) or cross(V(B_N)-vth));

    V(Y) <+ transition(!((V(A) > vth) || !(V(B_N) > vth)) ? vh : vl, td, tt);
end
endmodule

module sg13g2_nor2b_2 (Y, A, B_N);
    output Y;
    electrical Y;
    input A, B_N;
    electrical A, B_N;
    parameter real vh = 1.2; /* high level */
    parameter real vl = 0;   /* low level */
    parameter real vth = (vh + vl)/2;
    parameter real td = 0 from [0:inf);
    parameter real tt = 0 from [0:inf);
analog begin
    @(cross(V(A)-vth) or cross(V(B_N)-vth));

    V(Y) <+ transition(!((V(A) > vth) || !(V(B_N) > vth)) ? vh : vl, td, tt);
end
endmodule

module sg13g2_nor3_1 (Y, A, B, C);
    output Y;
    electrical Y;
    input A, B, C;
    electrical A, B, C;
    parameter real vh = 1.2; /* high level */
    parameter real vl = 0;   /* low level */
    parameter real vth = (vh + vl)/2;
    parameter real td = 0 from [0:inf);
    parameter real tt = 0 from [0:inf);
analog begin
    @(cross(V(A)-vth) or cross(V(B)-vth) or cross(V(C)-vth));

    V(Y) <+ transition(!((V(A) > vth)||(V(B) > vth)||(V(C) > vth)) ? vh : vl, td, tt);
end
endmodule

module sg13g2_nor3_2 (Y, A, B, C);
    output Y;
    electrical Y;
    input A, B, C;
    electrical A, B, C;
    parameter real vh = 1.2; /* high level */
    parameter real vl = 0;   /* low level */
    parameter real vth = (vh + vl)/2;
    parameter real td = 0 from [0:inf);
    parameter real tt = 0 from [0:inf);
analog begin
    @(cross(V(A)-vth) or cross(V(B)-vth) or cross(V(C)-vth));

    V(Y) <+ transition(!((V(A) > vth)||(V(B) > vth)||(V(C) > vth)) ? vh : vl, td, tt);
end
endmodule

module sg13g2_nor4_1 (Y, A, B, C, D);
    output Y;
    electrical Y;
    input A, B, C, D;
    electrical A, B, C, D;
    parameter real vh = 1.2; /* high level */
    parameter real vl = 0;   /* low level */
    parameter real vth = (vh + vl)/2;
    parameter real td = 0 from [0:inf);
    parameter real tt = 0 from [0:inf);
analog begin
    @(cross(V(A)-vth) or cross(V(B)-vth) or cross(V(C)-vth) or cross(V(D)-vth));

    V(Y) <+ transition(!((V(A) > vth)||(V(B) > vth)||(V(C) > vth)||(V(D) > vth)) ? vh : vl, td, tt);
end
endmodule

module sg13g2_nor4_2 (Y, A, B, C, D);
    output Y;
    electrical Y;
    input A, B, C, D;
    electrical A, B, C, D;
    parameter real vh = 1.2; /* high level */
    parameter real vl = 0;   /* low level */
    parameter real vth = (vh + vl)/2;
    parameter real td = 0 from [0:inf);
    parameter real tt = 0 from [0:inf);
analog begin
    @(cross(V(A)-vth) or cross(V(B)-vth) or cross(V(C)-vth) or cross(V(D)-vth));

    V(Y) <+ transition(!((V(A) > vth)||(V(B) > vth)||(V(C) > vth)||(V(D) > vth)) ? vh : vl, td, tt);
end
endmodule

module sg13g2_o21ai_1 (Y, A1, A2, B1);
    output Y;
    electrical Y;
    input A1, A2, B1;
    electrical A1, A2, B1;
    parameter real vh = 1.2; /* high level */
    parameter real vl = 0;   /* low level */
    parameter real vth = (vh + vl)/2;
    parameter real td = 0 from [0:inf);
    parameter real tt = 0 from [0:inf);
analog begin
    @(cross(V(A1)-vth) or cross(V(A2)-vth) or cross(V(B1)-vth));

    V(Y) <+ transition(!(((V(A1) > vth)||(V(A2) > vth)) && (V(B1) > vth)) ? vh : vl, td, tt);
end
endmodule

module sg13g2_or2_1 (X, A, B);
    output X;
    electrical X;
    input A, B;
    electrical A, B;
    parameter real vh = 1.2; /* high level */
    parameter real vl = 0;   /* low level */
    parameter real vth = (vh + vl)/2;
    parameter real td = 0 from [0:inf);
    parameter real tt = 0 from [0:inf);
analog begin
    @(cross(V(A) - vth) or cross(V(B) - vth));

    V(X) <+ transition(((V(A) > vth) || (V(B) > vth)) ? vh : vl, td, tt);
end
endmodule

module sg13g2_or2_2 (X, A, B);
    output X;
    electrical X;
    input A, B;
    electrical A, B;
    parameter real vh = 1.2; /* high level */
    parameter real vl = 0;   /* low level */
    parameter real vth = (vh + vl)/2;
    parameter real td = 0 from [0:inf);
    parameter real tt = 0 from [0:inf);
analog begin
    @(cross(V(A) - vth) or cross(V(B) - vth));

    V(X) <+ transition(((V(A) > vth) || (V(B) > vth)) ? vh : vl, td, tt);
end
endmodule

module sg13g2_or3_1 (X, A, B, C);
    output X;
    electrical X;
    input A, B, C;
    electrical A, B, C;
    parameter real vh = 1.2; /* high level */
    parameter real vl = 0;   /* low level */
    parameter real vth = (vh + vl)/2;
    parameter real td = 0 from [0:inf);
    parameter real tt = 0 from [0:inf);
analog begin
    @(cross(V(A) - vth) or cross(V(B) - vth) or cross(V(C) - vth));

    V(X) <+ transition(((V(A) > vth) || (V(B) > vth) || (V(C) > vth)) ? vh : vl, td, tt);
end
endmodule

module sg13g2_or3_2 (X, A, B, C);
    output X;
    electrical X;
    input A, B, C;
    electrical A, B, C;
    parameter real vh = 1.2; /* high level */
    parameter real vl = 0;   /* low level */
    parameter real vth = (vh + vl)/2;
    parameter real td = 0 from [0:inf);
    parameter real tt = 0 from [0:inf);
analog begin
    @(cross(V(A) - vth) or cross(V(B) - vth) or cross(V(C) - vth));

    V(X) <+ transition(((V(A) > vth) || (V(B) > vth) || (V(C) > vth)) ? vh : vl, td, tt);
end
endmodule

module sg13g2_or4_1 (X, A, B, C, D);
    output X;
    electrical X;
    input A, B, C, D;
    electrical A, B, C, D;
    parameter real vh = 1.2; /* high level */
    parameter real vl = 0;   /* low level */
    parameter real vth = (vh + vl)/2;
    parameter real td = 0 from [0:inf);
    parameter real tt = 0 from [0:inf);
analog begin
    @(cross(V(A) - vth) or cross(V(B) - vth) or cross(V(C) - vth) or cross(V(D) - vth));

    V(X) <+ transition(((V(A) > vth) || (V(B) > vth) || (V(C) > vth) || (V(D) > vth)) ? vh : vl, td, tt);
end
endmodule

module sg13g2_or4_2 (X, A, B, C, D);
    output X;
    electrical X;
    input A, B, C, D;
    electrical A, B, C, D;
    parameter real vh = 1.2; /* high level */
    parameter real vl = 0;   /* low level */
    parameter real vth = (vh + vl)/2;
    parameter real td = 0 from [0:inf);
    parameter real tt = 0 from [0:inf);
analog begin
    @(cross(V(A) - vth) or cross(V(B) - vth) or cross(V(C) - vth) or cross(V(D) - vth));

    V(X) <+ transition(((V(A) > vth) || (V(B) > vth) || (V(C) > vth) || (V(D) > vth)) ? vh : vl, td, tt);
end
endmodule

// Exclusive gates
module sg13g2_xor2_1 (X, A, B);
    output X;
    electrical X;
    input A, B;
    electrical A, B;
    parameter real vh = 1.2; /* high level */
    parameter real vl = 0;   /* low level */
    parameter real vth = (vh + vl)/2;
    parameter real td = 0 from [0:inf);
    parameter real tt = 0 from [0:inf);
analog begin
    @(cross(V(A)-vth) or cross(V(B)-vth));

    V(X) <+ transition(((V(A) > vth) ^ (V(B) > vth)) ? vh : vl, td, tt);
end
endmodule

module sg13g2_xnor2_1 (Y, A, B);
    output Y;
    electrical Y;
    input A, B;
    electrical A, B;
    parameter real vh = 1.2; /* high level */
    parameter real vl = 0;   /* low level */
    parameter real vth = (vh + vl)/2;
    parameter real td = 0 from [0:inf);
    parameter real tt = 0 from [0:inf);
analog begin
    @(cross(V(A)-vth) or cross(V(B)-vth));

    V(Y) <+ transition(((V(A) > vth) ~^ (V(B) > vth)) ? vh : vl, td, tt);
end
endmodule

// Tri-state and enable inverters
module sg13g2_ebufn_2 (Z, A, TE_B);
    inout Z;
    electrical Z;
    input A, TE_B;
    electrical A, TE_B;
    parameter real vh = 1.2; /* high level */
    parameter real vl = 0;   /* low level */
    parameter real vth = (vh + vl)/2;
    parameter real td = 0 from [0:inf);
    parameter real tt = 0 from [0:inf);
    real state;
analog begin
    @(cross(V(A)-vth) or cross(V(TE_B)-vth)) begin;

        if (!(V(TE_B) > vth))
            state = (V(A) > vth);
    end
    V(Z) <+ transition(state ? vh : vl, td, tt);
end
endmodule
module sg13g2_ebufn_4 (Z, A, TE_B);
    inout Z;
    electrical Z;
    input A, TE_B;
    electrical A, TE_B;
    parameter real vh = 1.2; /* high level */
    parameter real vl = 0;   /* low level */
    parameter real vth = (vh + vl)/2;
    parameter real td = 0 from [0:inf);
    parameter real tt = 0 from [0:inf);
    real state;
analog begin
    @(cross(V(A)-vth) or cross(V(TE_B)-vth)) begin;

        if (!(V(TE_B) > vth))
            state = (V(A) > vth);
    end
    V(Z) <+ transition(state ? vh : vl, td, tt);
end
endmodule
module sg13g2_ebufn_8 (Z, A, TE_B);
    inout Z;
    electrical Z;
    input A, TE_B;
    electrical A, TE_B;
    parameter real vh = 1.2; /* high level */
    parameter real vl = 0;   /* low level */
    parameter real vth = (vh + vl)/2;
    parameter real td = 0 from [0:inf);
    parameter real tt = 0 from [0:inf);
    real state;
analog begin
    @(cross(V(A)-vth) or cross(V(TE_B)-vth)) begin;

        if (!(V(TE_B) > vth))
            state = (V(A) > vth);
    end
    V(Z) <+ transition(state ? vh : vl, td, tt);
end
endmodule

module sg13g2_einvn_2 (Z, A, TE_B);
    inout Z;
    electrical Z;
    input A, TE_B;
    electrical A, TE_B;
    parameter real vh = 1.2; /* high level */
    parameter real vl = 0;   /* low level */
    parameter real vth = (vh + vl)/2;
    parameter real td = 0 from [0:inf);
    parameter real tt = 0 from [0:inf);
    real state;
analog begin
    @(cross(V(A)-vth) or cross(V(TE_B)-vth)) begin;

        if (!(V(TE_B) > vth))
            state = !(V(A) > vth);
    end
    V(Z) <+ transition(state ? vh : vl, td, tt);
end
endmodule
module sg13g2_einvn_4 (Z, A, TE_B);
    inout Z;
    electrical Z;
    input A, TE_B;
    electrical A, TE_B;
    parameter real vh = 1.2; /* high level */
    parameter real vl = 0;   /* low level */
    parameter real vth = (vh + vl)/2;
    parameter real td = 0 from [0:inf);
    parameter real tt = 0 from [0:inf);
    real state;
analog begin
    @(cross(V(A)-vth) or cross(V(TE_B)-vth)) begin;

        if (!(V(TE_B) > vth))
            state = !(V(A) > vth);
    end
    V(Z) <+ transition(state ? vh : vl, td, tt);
end
endmodule
module sg13g2_einvn_8 (Z, A, TE_B);
    inout Z;
    electrical Z;
    input A, TE_B;
    electrical A, TE_B;
    parameter real vh = 1.2; /* high level */
    parameter real vl = 0;   /* low level */
    parameter real vth = (vh + vl)/2;
    parameter real td = 0 from [0:inf);
    parameter real tt = 0 from [0:inf);
    real state;
analog begin
    @(cross(V(A)-vth) or cross(V(TE_B)-vth)) begin;

        if (!(V(TE_B) > vth))
            state = !(V(A) > vth);
    end
    V(Z) <+ transition(state ? vh : vl, td, tt);
end
endmodule

// Tie cells
module sg13g2_tiehi (L_HI);
    output L_HI;
    electrical L_HI;
    parameter real vh = 1.2; /* high level */
    parameter real vl = 0;   /* low level */
    parameter real vth = (vh + vl)/2;
    parameter real td = 0 from [0:inf);
    parameter real tt = 0 from [0:inf);
analog begin
    V(L_HI) <+ transition(vh, td, tt);
end
endmodule

module sg13g2_tielo (L_LO);
    output L_LO;
    electrical L_LO;
    parameter real vh = 1.2; /* high level */
    parameter real vl = 0;   /* low level */
    parameter real vth = (vh + vl)/2;
    parameter real td = 0 from [0:inf);
    parameter real tt = 0 from [0:inf);
analog begin
    V(L_LO) <+ transition(vl, td, tt);
end
endmodule

// Clock gating helpers
module sg13g2_lgcp_1 (GCLK, GATE, CLK);
    output GCLK;
    electrical GCLK;
    input GATE, CLK;
    electrical GATE, CLK;
    parameter real vh = 1.2; /* high level */
    parameter real vl = 0;   /* low level */
    parameter real vth = (vh + vl)/2;
    parameter real td = 0 from [0:inf);
    parameter real tt = 0 from [0:inf);
    real state;
analog begin
    @(cross(V(GATE)-vth) or cross(V(CLK)-vth)) begin;

        state = (V(GATE) > vth) && (V(CLK) > vth);
    end
    V(GCLK) <+ transition(state ? vh : vl, td, tt);
end
endmodule

module sg13g2_slgcp_1 (GCLK, GATE, SCE, CLK);
    output GCLK;
    electrical GCLK;
    input GATE, SCE, CLK;
    electrical GATE, SCE, CLK;
    parameter real vh = 1.2; /* high level */
    parameter real vl = 0;   /* low level */
    parameter real vth = (vh + vl)/2;
    parameter real td = 0 from [0:inf);
    parameter real tt = 0 from [0:inf);
    real state;
analog begin
    @(cross(V(GATE)-vth) or cross(V(SCE)-vth) or cross(V(CLK)-vth)) begin;

        state = (((V(GATE) > vth) && !(V(SCE) > vth)) || (V(SCE) > vth)) && (V(CLK) > vth);
    end
    V(GCLK) <+ transition(state ? vh : vl, td, tt);
end
endmodule

// Latches
module sg13g2_dlhq_1 (Q, D, GATE);
    output Q;
    electrical Q;
    input D, GATE;
    electrical D, GATE;
    parameter real vh = 1.2; /* high level */
    parameter real vl = 0;   /* low level */
    parameter real vth = (vh + vl)/2;
    parameter real td = 0 from [0:inf);
    parameter real tt = 0 from [0:inf);
    real state;
analog begin
    @(cross(V(D)-vth) or cross(V(GATE)-vth)) begin;

        if ((V(GATE) > vth))
            state = (V(D) > vth);
    end
    V(Q) <+ transition(state ? vh : vl, td, tt);
end
endmodule

module sg13g2_dlhr_1 (Q, Q_N, D, RESET_B, GATE);
    output Q, Q_N;
    electrical Q, Q_N;
    input D, RESET_B, GATE;
    electrical D, RESET_B, GATE;
    parameter real vh = 1.2; /* high level */
    parameter real vl = 0;   /* low level */
    parameter real vth = (vh + vl)/2;
    parameter real td = 0 from [0:inf);
    parameter real tt = 0 from [0:inf);
    real state;
analog begin
    @(cross(V(D)-vth) or cross(V(RESET_B)-vth) or cross(V(GATE)-vth)) begin;

        if (!(V(RESET_B) > vth))
            state = 0;
        else if ((V(GATE) > vth))
            state = (V(D) > vth);
    end
    V(Q)   <+ transition(state ? vh : vl, td, tt);
    V(Q_N) <+ transition(!state ? vh : vl, td, tt);
end
endmodule

module sg13g2_dlhrq_1 (Q, D, RESET_B, GATE);
    output Q;
    electrical Q;
    input D, RESET_B, GATE;
    electrical D, RESET_B, GATE;
    parameter real vh = 1.2; /* high level */
    parameter real vl = 0;   /* low level */
    parameter real vth = (vh + vl)/2;
    parameter real td = 0 from [0:inf);
    parameter real tt = 0 from [0:inf);
    real state;
analog begin
    @(cross(V(D)-vth) or cross(V(RESET_B)-vth) or cross(V(GATE)-vth)) begin;

        if (!(V(RESET_B) > vth))
            state = 0;
        else if ((V(GATE) > vth))
            state = (V(D) > vth);
    end
    V(Q) <+ transition(state ? vh : vl, td, tt);
end
endmodule

module sg13g2_dllr_1 (Q, Q_N, D, RESET_B, GATE_N);
    output Q, Q_N;
    electrical Q, Q_N;
    input D, RESET_B, GATE_N;
    electrical D, RESET_B, GATE_N;
    parameter real vh = 1.2; /* high level */
    parameter real vl = 0;   /* low level */
    parameter real vth = (vh + vl)/2;
    parameter real td = 0 from [0:inf);
    parameter real tt = 0 from [0:inf);
    real state;
analog begin
    @(cross(V(D)-vth) or cross(V(RESET_B)-vth) or cross(V(GATE_N)-vth)) begin;

        if (!(V(RESET_B) > vth))
            state = 0;
        else if (!(V(GATE_N) > vth))
            state = (V(D) > vth);
    end
    V(Q)   <+ transition(state ? vh : vl, td, tt);
    V(Q_N) <+ transition(!state ? vh : vl, td, tt);
end
endmodule

module sg13g2_dllrq_1 (Q, D, RESET_B, GATE_N);
    output Q;
    electrical Q;
    input D, RESET_B, GATE_N;
    electrical D, RESET_B, GATE_N;
    parameter real vh = 1.2; /* high level */
    parameter real vl = 0;   /* low level */
    parameter real vth = (vh + vl)/2;
    parameter real td = 0 from [0:inf);
    parameter real tt = 0 from [0:inf);
    real state;
analog begin
    @(cross(V(D)-vth) or cross(V(RESET_B)-vth) or cross(V(GATE_N)-vth)) begin;

        if (!(V(RESET_B) > vth))
            state = 0;
        else if (!(V(GATE_N) > vth))
            state = (V(D) > vth);
    end
    V(Q) <+ transition(state ? vh : vl, td, tt);
end
endmodule

// D flip-flops
module sg13g2_dfrbp_1 (Q, Q_N, D, RESET_B, CLK);
    output Q, Q_N;
    electrical Q, Q_N;
    input D, RESET_B, CLK;
    electrical D, RESET_B, CLK;
    parameter real vh = 1.2; /* high level */
    parameter real vl = 0;   /* low level */
    parameter real vth = (vh + vl)/2;
    parameter real td = 0 from [0:inf);
    parameter real tt = 0 from [0:inf);
    real state;
analog begin
    @(cross(V(RESET_B)-vth) or cross(V(CLK)-vth, +1) or cross(V(D)-vth)) begin;

        if (!(V(RESET_B) > vth))
            state = 0;
        else if (cross(V(CLK)-vth, +1))
            state = (V(D) > vth);
    end
    V(Q)   <+ transition(state ? vh : vl, td, tt);
    V(Q_N) <+ transition(!state ? vh : vl, td, tt);
end
endmodule

module sg13g2_dfrbp_2 (Q, Q_N, D, RESET_B, CLK);
    output Q, Q_N;
    electrical Q, Q_N;
    input D, RESET_B, CLK;
    electrical D, RESET_B, CLK;
    parameter real vh = 1.2; /* high level */
    parameter real vl = 0;   /* low level */
    parameter real vth = (vh + vl)/2;
    parameter real td = 0 from [0:inf);
    parameter real tt = 0 from [0:inf);
    real state;
analog begin
    @(cross(V(RESET_B)-vth) or cross(V(CLK)-vth, +1) or cross(V(D)-vth)) begin;

        if (!(V(RESET_B) > vth))
            state = 0;
        else if (cross(V(CLK)-vth, +1))
            state = (V(D) > vth);
    end
    V(Q)   <+ transition(state ? vh : vl, td, tt);
    V(Q_N) <+ transition(!state ? vh : vl, td, tt);
end
endmodule

module sg13g2_dfrbpq_1 (Q, D, RESET_B, CLK);
    output Q;
    electrical Q;
    input D, RESET_B, CLK;
    electrical D, RESET_B, CLK;
    parameter real vh = 1.2; /* high level */
    parameter real vl = 0;   /* low level */
    parameter real vth = (vh + vl)/2;
    parameter real td = 0 from [0:inf);
    parameter real tt = 0 from [0:inf);
    real state;
analog begin
    @(cross(V(RESET_B)-vth) or cross(V(CLK)-vth, +1) or cross(V(D)-vth)) begin;

        if (!(V(RESET_B) > vth))
            state = 0;
        else if (cross(V(CLK)-vth, +1))
            state = (V(D) > vth);
    end
    V(Q) <+ transition(state ? vh : vl, td, tt);
end
endmodule

module sg13g2_dfrbpq_2 (Q, D, RESET_B, CLK);
    output Q;
    electrical Q;
    input D, RESET_B, CLK;
    electrical D, RESET_B, CLK;
    parameter real vh = 1.2; /* high level */
    parameter real vl = 0;   /* low level */
    parameter real vth = (vh + vl)/2;
    parameter real td = 0 from [0:inf);
    parameter real tt = 0 from [0:inf);
    real state;
analog begin
    @(cross(V(RESET_B)-vth) or cross(V(CLK)-vth, +1) or cross(V(D)-vth)) begin;

        if (!(V(RESET_B) > vth))
            state = 0;
        else if (cross(V(CLK)-vth, +1))
            state = (V(D) > vth);
    end
    V(Q) <+ transition(state ? vh : vl, td, tt);
end
endmodule

// Scan DFF with reset and optional set
module sg13g2_sdfbbp_1 (Q, Q_N, D, SCD, SCE, RESET_B, SET_B, CLK);
    output Q, Q_N;
    electrical Q, Q_N;
    input D, SCD, SCE, RESET_B, SET_B, CLK;
    electrical D, SCD, SCE, RESET_B, SET_B, CLK;
    parameter real vh = 1.2; /* high level */
    parameter real vl = 0;   /* low level */
    parameter real vth = (vh + vl)/2;
    parameter real td = 0 from [0:inf);
    parameter real tt = 0 from [0:inf);
    real state;
analog begin
    @(cross(V(D)-vth) or cross(V(SCD)-vth) or cross(V(SCE)-vth) or cross(V(RESET_B)-vth) or cross(V(SET_B)-vth) or cross(V(CLK)-vth, +1)) begin;

        if (!(V(RESET_B) > vth))
            state = 0;
        else if (!(V(SET_B) > vth))
            state = 1;
        else if (cross(V(CLK)-vth, +1))
            state = (V(SCE) > vth) ? (V(SCD) > vth) : (V(D) > vth);
    end
    V(Q)   <+ transition(state ? vh : vl, td, tt);
    V(Q_N) <+ transition(!state ? vh : vl, td, tt);
end
endmodule

module sg13g2_sdfrbp_1 (Q, Q_N, D, SCD, SCE, RESET_B, CLK);
    output Q, Q_N;
    electrical Q, Q_N;
    input D, SCD, SCE, RESET_B, CLK;
    electrical D, SCD, SCE, RESET_B, CLK;
    parameter real vh = 1.2; /* high level */
    parameter real vl = 0;   /* low level */
    parameter real vth = (vh + vl)/2;
    parameter real td = 0 from [0:inf);
    parameter real tt = 0 from [0:inf);
    real state;
analog begin
    @(cross(V(D)-vth) or cross(V(SCD)-vth) or cross(V(SCE)-vth) or cross(V(RESET_B)-vth) or cross(V(CLK)-vth, +1)) begin;

        if (!(V(RESET_B) > vth))
            state = 0;
        else if (cross(V(CLK)-vth, +1))
            state = (V(SCE) > vth) ? (V(SCD) > vth) : (V(D) > vth);
    end
    V(Q)   <+ transition(state ? vh : vl, td, tt);
    V(Q_N) <+ transition(!state ? vh : vl, td, tt);
end
endmodule

module sg13g2_sdfrbp_2 (Q, Q_N, D, SCD, SCE, RESET_B, CLK);
    output Q, Q_N;
    electrical Q, Q_N;
    input D, SCD, SCE, RESET_B, CLK;
    electrical D, SCD, SCE, RESET_B, CLK;
    parameter real vh = 1.2; /* high level */
    parameter real vl = 0;   /* low level */
    parameter real vth = (vh + vl)/2;
    parameter real td = 0 from [0:inf);
    parameter real tt = 0 from [0:inf);
    real state;
analog begin
    @(cross(V(D)-vth) or cross(V(SCD)-vth) or cross(V(SCE)-vth) or cross(V(RESET_B)-vth) or cross(V(CLK)-vth, +1)) begin;

        if (!(V(RESET_B) > vth))
            state = 0;
        else if (cross(V(CLK)-vth, +1))
            state = (V(SCE) > vth) ? (V(SCD) > vth) : (V(D) > vth);
    end
    V(Q)   <+ transition(state ? vh : vl, td, tt);
    V(Q_N) <+ transition(!state ? vh : vl, td, tt);
end
endmodule

module sg13g2_sdfrbpq_1 (Q, D, SCD, SCE, RESET_B, CLK);
    output Q;
    electrical Q;
    input D, SCD, SCE, RESET_B, CLK;
    electrical D, SCD, SCE, RESET_B, CLK;
    parameter real vh = 1.2; /* high level */
    parameter real vl = 0;   /* low level */
    parameter real vth = (vh + vl)/2;
    parameter real td = 0 from [0:inf);
    parameter real tt = 0 from [0:inf);
    real state;
analog begin
    @(cross(V(D)-vth) or cross(V(SCD)-vth) or cross(V(SCE)-vth) or cross(V(RESET_B)-vth) or cross(V(CLK)-vth, +1)) begin;

        if (!(V(RESET_B) > vth))
            state = 0;
        else if (cross(V(CLK)-vth, +1))
            state = (V(SCE) > vth) ? (V(SCD) > vth) : (V(D) > vth);
    end
    V(Q) <+ transition(state ? vh : vl, td, tt);
end
endmodule

module sg13g2_sdfrbpq_2 (Q, D, SCD, SCE, RESET_B, CLK);
    output Q;
    electrical Q;
    input D, SCD, SCE, RESET_B, CLK;
    electrical D, SCD, SCE, RESET_B, CLK;
    parameter real vh = 1.2; /* high level */
    parameter real vl = 0;   /* low level */
    parameter real vth = (vh + vl)/2;
    parameter real td = 0 from [0:inf);
    parameter real tt = 0 from [0:inf);
    real state;
analog begin
    @(cross(V(D)-vth) or cross(V(SCD)-vth) or cross(V(SCE)-vth) or cross(V(RESET_B)-vth) or cross(V(CLK)-vth, +1)) begin;

        if (!(V(RESET_B) > vth))
            state = 0;
        else if (cross(V(CLK)-vth, +1))
            state = (V(SCE) > vth) ? (V(SCD) > vth) : (V(D) > vth);
    end
    V(Q) <+ transition(state ? vh : vl, td, tt);
end
endmodule

// Bus hold cell
module sg13g2_sighold (SH);
    inout SH;
    electrical SH;
    parameter real vh = 1.2; /* high level */
    parameter real vl = 0;   /* low level */
    parameter real vth = (vh + vl)/2;
    parameter real td = 0 from [0:inf);
    parameter real tt = 0 from [0:inf);
    real state;
analog begin
    @(cross(V(SH)-vth)) state = (V(SH) > vth);

    V(SH) <+ transition(state ? vh : vl, td, tt);
end
endmodule

// Delay cells modeled as buffers
module sg13g2_dlygate4sd1_1 (X, A);
    output X;
    electrical X;
    input A;
    electrical A;
    sg13g2_buf_base buf_i(.X(X), .A(A));
endmodule
module sg13g2_dlygate4sd2_1 (X, A);
    output X;
    electrical X;
    input A;
    electrical A;
    sg13g2_buf_base buf_i(.X(X), .A(A));
endmodule
module sg13g2_dlygate4sd3_1 (X, A);
    output X;
    electrical X;
    input A;
    electrical A;
    sg13g2_buf_base buf_i(.X(X), .A(A));
endmodule
